* (b) [tier T3] higher-fidelity transient, output fall, corner tt, VDD = 1.8 V, 27 C, external load 5 fF
* ==========================================================================
* voltage-to-bit, workstream D.   STATUS: PROPOSED, NOT RUN.
* This deck has never been executed (ngspice is not installed here; the owner
* decides whether to install it). Generated by experiments/v2b/spice.py from
* the design record; do not edit by hand.
* design record: illustrative-1v8   sha256: 06ccc32a64938f43350d6fb68d991c15e62b9d6815f0b174391be073727bc967
* ==========================================================================
* DEVICE MODEL RECOMMENDED BY WORKSTREAM B (docs/model.md section 9), NOT YET FROZEN IN THE INTERFACE:
* SkyWater SKY130 BSIM4 (level 54), sky130_fd_pr__nfet_01v8 and sky130_fd_pr__pfet_01v8_hvt, sized as
* sky130_fd_sc_hd__inv_1 (N 0.65/0.15 um, P 1.0/0.15 um). Source to pin (docs/model.md 9.2):
* github.com/fossi-foundation/skywater-pdk-libs-sky130_fd_pr at 403964dc7f9cca5ec1a8cc7b4f2a6f532b781676,
* entry point models/sky130.lib.spice. Record the SHA-256 of every model file actually loaded.
* The design record is ILLUSTRATIVE (not derived from this process): no agreement is expected a priori.
* Replace SKY130_PR_PLACEHOLDER by the location of that checkout (run_ngspice.py does this from the
* SKY130_PR environment variable). VERIFY ON FIRST RUN: library path and section names, instance
* parameter units (the library sets its own `scale`), drain/source areas (the cell netlist gives none),
* and the ngspice settings recommended for this PDK (`set ngbehavior=hsa`, `set skywaterpdk`). Those two
* settings act when the netlist is parsed and normally belong in .spiceinit; they are repeated in the
* .control block below only as a reminder.
* Full-swing input ramp at 20 V/ns; the input crosses the band edge (1.25 V) at s = 0.2625 ns.
* Compared with: formal bound tau = 2.56015669 ns (delay from s to the output threshold), the safe
* domain [-0.1, 2.08] V (overshoot from gate-drain feedthrough is expected), and the
* inclusion residual along the waveform: distance of c*dv/dt from [min_theta I_net - eps_I, max_theta I_net + eps_I].
.options TEMP=27
.lib "SKY130_PR_PLACEHOLDER/models/sky130.lib.spice" tt
VDD vdd 0 DC 1.8
VIN in 0 PWL(0 0 0.2n 0 0.29n 1.8)
CL out 0 5f
XMP out in vdd vdd sky130_fd_pr__pfet_01v8_hvt L=0.15 W=1 nf=1 mult=1
XMN out in 0 0 sky130_fd_pr__nfet_01v8 L=0.15 W=0.65 nf=1 mult=1
.ic v(out)=1.8
.control
set ngbehavior=hsa
set skywaterpdk
set wr_singlescale
set wr_vecnames
set numdgt=12
tran 1p 3.9627n 0 1p
wrdata sky130_tran_fall_tt_vdd1p8_t27_c5.dat v(out) v(in) i(VDD)
.endc
.end
