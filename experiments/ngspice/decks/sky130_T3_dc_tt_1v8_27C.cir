* (b) [tier T3] higher-fidelity DC map of the net output-node current, process corner tt, VDD = 1.8 V, 27 C
* ==========================================================================
* voltage-to-bit, workstream D.   STATUS: PROPOSED, NOT RUN.
* This deck has never been executed (ngspice is not installed here; the owner
* decides whether to install it). Generated by experiments/v2b/spice.py from
* the design record; do not edit by hand.
* design record: illustrative-1v8   sha256: 06ccc32a64938f43350d6fb68d991c15e62b9d6815f0b174391be073727bc967
* ==========================================================================
* DEVICE MODEL RECOMMENDED BY WORKSTREAM B (docs/model.md section 9), NOT YET FROZEN IN THE INTERFACE:
* SkyWater SKY130 BSIM4 (level 54), sky130_fd_pr__nfet_01v8 and sky130_fd_pr__pfet_01v8_hvt, sized as
* sky130_fd_sc_hd__inv_1 (N 0.65/0.15 um, P 1.0/0.15 um). Source to pin (docs/model.md 9.2):
* github.com/fossi-foundation/skywater-pdk-libs-sky130_fd_pr at 403964dc7f9cca5ec1a8cc7b4f2a6f532b781676,
* entry point models/sky130.lib.spice. Record the SHA-256 of every model file actually loaded.
* The design record is ILLUSTRATIVE (not derived from this process): no agreement is expected a priori.
* Replace SKY130_PR_PLACEHOLDER by the location of that checkout (run_ngspice.py does this from the
* SKY130_PR environment variable). VERIFY ON FIRST RUN: library path and section names, instance
* parameter units (the library sets its own `scale`), drain/source areas (the cell netlist gives none),
* and the ngspice settings recommended for this PDK (`set ngbehavior=hsa`, `set skywaterpdk`). Those two
* settings act when the netlist is parsed and normally belong in .spiceinit; they are repeated in the
* .control block below only as a reminder.
* Compared with: the tube [min, max] of I_net(u, v; theta) over the parameter box (sandwich obligation of
* interface.md v1 rev. 2), and the four current margins evaluated directly on this map.
.options TEMP=27
.lib "SKY130_PR_PLACEHOLDER/models/sky130.lib.spice" tt
VDD vdd 0 DC 1.8
VIN in 0 DC 0
VOUT out 0 DC 0
XMP out in vdd vdd sky130_fd_pr__pfet_01v8_hvt L=0.15 W=1 nf=1 mult=1
XMN out in 0 0 sky130_fd_pr__nfet_01v8 L=0.15 W=0.65 nf=1 mult=1
.control
set ngbehavior=hsa
set skywaterpdk
set wr_singlescale
set wr_vecnames
set numdgt=12
dc VOUT -0.1 2.08 0.02 VIN -0.1 2.08 0.02
wrdata sky130_dc_tt_vdd1p8_t27.dat i(VOUT) v(in)
.endc
.end
