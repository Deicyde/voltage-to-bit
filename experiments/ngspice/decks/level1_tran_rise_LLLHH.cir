* (a) [tier T1] Level-1 transient, output rise at corner LLLHH, C = C_max, worst-case constant disturbance
* ==========================================================================
* voltage-to-bit, workstream D.   STATUS: PROPOSED, NOT RUN.
* This deck has never been executed (ngspice is not installed here; the owner
* decides whether to install it). Generated by experiments/v2b/spice.py from
* the design record; do not edit by hand.
* design record: illustrative-1v8   sha256: 06ccc32a64938f43350d6fb68d991c15e62b9d6815f0b174391be073727bc967
* ==========================================================================
* Input reaches the valid-band edge (0.4 V) at s = 0.84 ns; output threshold 1.35 V; formal bound tau = 3.4214252 ns.
* Compared with: Python simulation of the same theta, C, u(t), w(t), v(0): crossing time of the output
* threshold after s, and the sampled waveform (expected agreement at the level of the SPICE tolerances).
.options TEMP=27 TNOM=27 RELTOL=1e-6
* Level 1 (Shichman-Hodges), LAMBDA=0, GAMMA=0, W=L so that beta = KP.  k [uA/V^2] -> KP [A/V^2].
* TOX, CGSO, CGDO, CGBO, CBD, CBS, CJ are deliberately NOT given: the formal model has no device
* capacitance.  VERIFY ON FIRST RUN that `show` reports zero cgs/cgd/cbd/cbs (Meyer capacitances are
* believed to be disabled when TOX is absent; this has not been checked against this ngspice build).
* IS=1e-30 (as proposed in docs/model.md 9.4): with the default IS=1e-14 A the PMOS drain junction
* would carry about 0.5 uA at v = V_hi when VDD = VDD_min (0.46 V forward bias) and spoil the identity
* check there. GMIN stays at its default 1e-12 S (about 2e-6 uA across 2 V), the expected residual floor.
.model NFORMAL NMOS (LEVEL=1 VTO=0.6 KP=160u LAMBDA=0 GAMMA=0 PHI=0.6 IS=1e-30)
.model PFORMAL PMOS (LEVEL=1 VTO=-0.6 KP=80u LAMBDA=0 GAMMA=0 PHI=0.6 IS=1e-30)
VDD vdd 0 DC 1.62
VIN in 0 PWL(0 1.98 0.05n 1.98 0.84n 0.4)
* disturbance: -2 uA INTO the output node (I n+ n-: current flows n+ -> source -> n-)
IW 0 out DC -2u
CL out 0 20f IC=-0.1
MP out in vdd vdd PFORMAL W=1u L=1u
MN out in 0 0 NFORMAL W=1u L=1u
.ic v(out)=-0.1
.control
set wr_singlescale
set wr_vecnames
set numdgt=12
tran 1p 5.61678n 0 1p uic
wrdata level1_tran_rise_LLLHH.dat v(out) v(in)
.endc
.end
