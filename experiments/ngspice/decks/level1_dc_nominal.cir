* (a) [tier T1] Level-1 DC map of I_net(u, v) at corner nominal: VDD=1.8, kn=200, kp=100, Vtn=0.525, Vtp=0.525
* ==========================================================================
* voltage-to-bit, workstream D.   STATUS: PROPOSED, NOT RUN.
* This deck has never been executed (ngspice is not installed here; the owner
* decides whether to install it). Generated by experiments/v2b/spice.py from
* the design record; do not edit by hand.
* design record: illustrative-1v8   sha256: 06ccc32a64938f43350d6fb68d991c15e62b9d6815f0b174391be073727bc967
* ==========================================================================
* Compared with: Python I_net(u, v; theta) at the same grid points (expected agreement ~1e-5 uA).
* Sign: I_net into the output node = +i(VOUT) (current from the + node through the source to ground).
.options TEMP=27 TNOM=27 RELTOL=1e-6
* Level 1 (Shichman-Hodges), LAMBDA=0, GAMMA=0, W=L so that beta = KP.  k [uA/V^2] -> KP [A/V^2].
* TOX, CGSO, CGDO, CGBO, CBD, CBS, CJ are deliberately NOT given: the formal model has no device
* capacitance.  VERIFY ON FIRST RUN that `show` reports zero cgs/cgd/cbd/cbs (Meyer capacitances are
* believed to be disabled when TOX is absent; this has not been checked against this ngspice build).
* IS=1e-30 (as proposed in docs/model.md 9.4): with the default IS=1e-14 A the PMOS drain junction
* would carry about 0.5 uA at v = V_hi when VDD = VDD_min (0.46 V forward bias) and spoil the identity
* check there. GMIN stays at its default 1e-12 S (about 2e-6 uA across 2 V), the expected residual floor.
.model NFORMAL NMOS (LEVEL=1 VTO=0.525 KP=200u LAMBDA=0 GAMMA=0 PHI=0.6 IS=1e-30)
.model PFORMAL PMOS (LEVEL=1 VTO=-0.525 KP=100u LAMBDA=0 GAMMA=0 PHI=0.6 IS=1e-30)
VDD vdd 0 DC 1.8
VIN in 0 DC 0
VOUT out 0 DC 0
MP out in vdd vdd PFORMAL W=1u L=1u
MN out in 0 0 NFORMAL W=1u L=1u
.control
set wr_singlescale
set wr_vecnames
set numdgt=12
dc VOUT -0.1 2.08 0.02 VIN -0.5 2.48 0.05
wrdata level1_dc_nominal.dat i(VOUT) v(in)
show MN : cgs cgd cbd cbs
show MP : cgs cgd cbd cbs
.endc
.end
